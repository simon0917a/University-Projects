* C:\Users\user\Desktop\graphics assign3\23097293A.sch

* Schematics Version 9.1 - Web Update 1
* Thu Nov 14 11:12:19 2024

** Analysis setup **
.tran 20ns 10ms 0 0.01us
.OP

* From [PSPICE NETLIST] section of pspiceev.ini:
.lib "nom.lib"

.INC "23097293A.net"
.INC "23097293A.als"

.probe

.END
